ADE simulation setup
Run mode: Single Run, Sweeps and Corners
Tests:
  Prelab_Inverter_NOR2_2X_DUT_1: Prelab_Inverter/NOR2_2X_DUT/schematic, simulator spectre
