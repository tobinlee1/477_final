ADE simulation setup
Test Prelab_Inverter_Inv_1x_DUT_1: Prelab_Inverter/Inv_1x_DUT/schematic, simulator spectre
  Models: /home/ee577@vlab.usc.edu/CDS_GPDK45/gpdk045_v_5_0/gpdk045/../models/spectre/gpdk045.scs[mc]
  Temperature: 27
  Stimulus vdd: voltage dc dc=1 srcType=dc
  Stimulus gnd: voltage dc dc=0 srcType=dc
  Stimulus in_A: voltage bit val1=1 val0=0 rise=10p fall=10p period=1n srcType=bit data=1010
  Analysis tran: stop=10n
  Signals: /dut_in, /dut_out, /net1
Run mode: Single Run, Sweeps and Corners
