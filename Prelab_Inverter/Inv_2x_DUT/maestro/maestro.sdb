ADE simulation setup
Run mode: Single Run, Sweeps and Corners
Tests:
  Prelab_Inverter_Inv_2x_DUT_1: Prelab_Inverter/Inv_2x_DUT/schematic, simulator spectre
