ADE simulation setup
Run mode: Single Run, Sweeps and Corners
Tests:
  Prelab_Inverter_Inverter_1: Prelab_Inverter/Inverter/schematic, simulator spectre
