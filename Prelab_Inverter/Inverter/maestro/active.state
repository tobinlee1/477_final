ADE simulation setup
Test Prelab_Inverter_Inverter_1: Prelab_Inverter/Inverter/schematic, simulator spectre
  Models: /home/ee577@vlab.usc.edu/CDS_GPDK45/gpdk045_v_5_0/gpdk045/../models/spectre/gpdk045.scs[mc]
  Temperature: 27
  Stimulus vdd: voltage dc dc=1 srcType=dc
  Stimulus gnd: voltage dc dc=0 srcType=dc
  Stimulus in_a: voltage bit val1=1 val0=0 rise=10p fall=10p period=1n srcType=bit data=1010
  Analysis tran: stop=10n
  Signals: /vdd, /in_a, /out_a, /gnd
Run mode: Single Run, Sweeps and Corners
