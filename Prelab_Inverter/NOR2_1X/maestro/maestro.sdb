ADE simulation setup
Run mode: Single Run, Sweeps and Corners
Tests:
  Prelab_Inverter_NOR2_1X_1: Prelab_Inverter/NOR2_1X/schematic, simulator spectre
