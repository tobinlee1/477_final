ADE simulation setup
Test Prelab_Inverter_NAND2_1X_DUT_1: Prelab_Inverter/NAND2_1X_DUT/schematic, simulator spectre
  Models: /home/ee577@vlab.usc.edu/CDS_GPDK45/gpdk045_v_5_0/gpdk045/../models/spectre/gpdk045.scs[mc]
  Temperature: 27
  Stimulus stim_A: voltage bit val1=1 val0=0 rise=10p fall=10p period=1n srcType=bit data=1100
  Stimulus stim_B: voltage bit val1=1 val0=0 rise=10p fall=10p period=1n srcType=bit data=1001
  Stimulus gnd: voltage dc dc=0 srcType=dc
  Stimulus vdd: voltage dc dc=1 srcType=dc
  Analysis tran: stop=10n
  Signals: /stim_A, /stim_B, /vdd, /gnd, /DUT_inA, /DUT_inB, /DUT_out
Run mode: Single Run, Sweeps and Corners
