ADE simulation setup
Run mode: Single Run, Sweeps and Corners
Tests:
  fsm_3nor_1: fsm/3nor/schematic, simulator spectre
