ADE simulation setup
Test fsm_3nor_1: fsm/3nor/schematic, simulator spectre
  Models: /home/ee577@vlab.usc.edu/CDS_GPDK45/gpdk045_v_5_0/gpdk045/../models/spectre/gpdk045.scs[mc]
  Temperature: 27
  Stimulus a: voltage bit val1=1 val0=0 rise=10p fall=10p period=1n srcType=bit data=1110
  Stimulus b: voltage bit val1=1 val0=0 rise=10p fall=10p period=1n srcType=bit data=1000
  Stimulus c: voltage bit val1=1 val0=0 rise=10p fall=10p period=1n srcType=bit data=1100
  Stimulus gnd: voltage dc dc=0 srcType=dc
  Stimulus Vdd: voltage dc dc=1 srcType=dc
  Analysis tran: stop=10n
  Signals: /out, /c, /b, /a
Run mode: Single Run, Sweeps and Corners
