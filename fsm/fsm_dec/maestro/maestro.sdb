ADE simulation setup
Run mode: Single Run, Sweeps and Corners
Tests:
  fsm_fsm_dec_1: fsm/fsm_dec/schematic, simulator spectre
