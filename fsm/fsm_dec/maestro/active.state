ADE simulation setup
Test fsm_fsm_dec_1: fsm/fsm_dec/schematic, simulator spectre
  Models: /home/ee577@vlab.usc.edu/CDS_GPDK45/gpdk045_v_5_0/gpdk045/../models/spectre/gpdk045.scs[mc]
  Temperature: 27
  Files: vectors /home/tobinlee@vlab.usc.edu/work_gpdk045/VEC_files/t5_fsm_dec.vec
  Stimulus Vdd: voltage dc dc=1 srcType=dc
  Stimulus gnd: voltage dc dc=0 srcType=dc
  Analysis tran: stop=90n
  Signals: /S_ADD, /S_AND, /S_DONE, /S_IDLE, /S_OR, /S_SHL, /S_SUB, /S_XOR
Run mode: Single Run, Sweeps and Corners
