ADE simulation setup
Test lab3-TobinLee_4_bit_CSA_1: lab3-TobinLee/4_bit_CSA/schematic, simulator spectre
  Models: /home/ee577@vlab.usc.edu/CDS_GPDK45/gpdk045_v_5_0/gpdk045/../models/spectre/gpdk045.scs[mc]
  Temperature: 27
  Files: vectors /home/tobinlee@vlab.usc.edu/work_gpdk045/VEC_files/adder_4bit_example.vec
  Stimulus gnd: voltage dc dc=0 srcType=dc
  Stimulus vdd: voltage dc dc=1 srcType=dc
  Analysis tran: stop=12n
  Signals: /a1, /b1, /a2, /b2, /a3, /b3, /a4, /b4, /c0, /s1, /s2, /s3, /s4, /c1
Run mode: Single Run, Sweeps and Corners
