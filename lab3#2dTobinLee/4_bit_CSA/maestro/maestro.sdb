ADE simulation setup
Run mode: Single Run, Sweeps and Corners
Tests:
  lab3-TobinLee_4_bit_CSA_1: lab3-TobinLee/4_bit_CSA/schematic, simulator spectre
