ADE simulation setup
Test lab3-TobinLee_8_bit_CSA_1: lab3-TobinLee/8_bit_CSA/schematic, simulator spectre
  Models: /home/ee577@vlab.usc.edu/CDS_GPDK45/gpdk045_v_5_0/gpdk045/../models/spectre/gpdk045.scs[mc]
  Temperature: 27
  Files: vectors /home/tobinlee@vlab.usc.edu/work_gpdk045/VEC_files/file_simple_8-bit1.vec
  Stimulus vdd: voltage dc dc=1 srcType=dc
  Stimulus gnd: voltage dc dc=0 srcType=dc
  Analysis tran: stop=12n
  Signals: /A0, /A1, /A2, /A3, /A4, /A5, /A6, /A7, /B0, /B1, /B2, /B3, /B4, /B5, /B6, /B7, /C0, /C1, /S1, /S2, /S3, /S4, /S5, /S6, /S7, /S0
Run mode: Single Run, Sweeps and Corners
