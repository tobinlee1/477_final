ADE simulation setup
Test lab3-TobinLee_8_bit_CSA_Testbench_1: lab3-TobinLee/8_bit_CSA_Testbench/config, simulator spectre
  Models: /home/ee577@vlab.usc.edu/CDS_GPDK45/gpdk045_v_5_0/gpdk045/../models/spectre/gpdk045.scs[mc]
  Temperature: 27
  Files: vectors /home/tobinlee@vlab.usc.edu/work_gpdk045/VEC_files/file_simple_8-bit1.vec
  Stimulus vdd: voltage dc dc=1 srcType=dc
  Stimulus gnd: voltage dc dc=0 srcType=dc
  Analysis tran: stop=12n
  Signals: /AA0, /AA1, /AA2, /AA3, /AA4, /AA6, /AA7, /BB0, /BB1, /BB2, /BB3, /BB4, /BB5, /BB6, /BB7, /CC0, /CC1, /SS0, /SS1, /SS2, /SS3, /SS4, /SS5, /SS6, /SS7
Run mode: Single Run, Sweeps and Corners
