ADE simulation setup
Run mode: Single Run, Sweeps and Corners
Tests:
  lab3-TobinLee_8_bit_CSA_Testbench_1: lab3-TobinLee/8_bit_CSA_Testbench/config, simulator spectre
