ADE simulation setup
Run mode: Single Run, Sweeps and Corners
Tests:
  lab3-TobinLee_MUX_Testbech_1: lab3-TobinLee/MUX_Testbech/schematic, simulator spectre
