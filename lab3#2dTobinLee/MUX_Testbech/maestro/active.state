ADE simulation setup
Test lab3-TobinLee_MUX_Testbech_1: lab3-TobinLee/MUX_Testbech/schematic, simulator spectre
  Models: /home/ee577@vlab.usc.edu/CDS_GPDK45/gpdk045_v_5_0/gpdk045/../models/spectre/gpdk045.scs[mc]
  Temperature: 27
  Stimulus in_a: voltage bit val1=1 val0=0 rise=10p fall=10p period=1n srcType=bit data=1110000
  Stimulus in_b: voltage bit val1=1 val0=0 rise=10p fall=10p period=1n srcType=bit data=0000111
  Stimulus in_s: voltage bit val1=1 val0=0 rise=10p fall=10p period=1n srcType=bit data=0100010
  Stimulus vdd: voltage dc dc=1 srcType=dc
  Stimulus gnd: voltage dc dc=0 srcType=dc
  Analysis tran: stop=10n
  Signals: /dut_in_a, /dut_in_s, /dut_in_b, /dut_out_a
Run mode: Single Run, Sweeps and Corners
