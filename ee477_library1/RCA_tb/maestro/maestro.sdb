ADE simulation setup
Run mode: Single Run, Sweeps and Corners
Tests:
  ee477_library1_RCA_tb_1: ee477_library1/RCA_tb/schematic, simulator spectre
