ADE simulation setup
Test ee477_library1_RCA_tb_1: ee477_library1/RCA_tb/schematic, simulator spectre
  Models: /home/ee577@vlab.usc.edu/CDS_GPDK45/gpdk045_v_5_0/gpdk045/../models/spectre/gpdk045.scs[mc]
  Temperature: 27
  Stimulus gnd: voltage dc dc=0 srcType=dc
  Stimulus Vdd: voltage dc dc=1 srcType=dc
  Stimulus A0: voltage dc dc=1 srcType=dc
  Stimulus A1: voltage dc dc=1 srcType=dc
  Stimulus A2: voltage dc dc=1 srcType=dc
  Stimulus A3: voltage dc dc=1 srcType=dc
  Stimulus B0: voltage dc dc=0 srcType=dc
  Stimulus B1: voltage dc dc=0 srcType=dc
  Stimulus B2: voltage dc dc=0 srcType=dc
  Stimulus B3: voltage dc dc=0 srcType=dc
  Stimulus C0: voltage bit val1=1 val0=0 rise=10ps fall=10ps period=1n srcType=bit data=101010
  Analysis tran: stop=10n
  Signals: /A0, /A1, /A2, /A3, /B0, /B1, /B2, /B3, /C0, /Vdd, /gnd, /S0, /S1, /S2, /S3, /Cout
Run mode: Single Run, Sweeps and Corners
