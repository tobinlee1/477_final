ADE simulation setup
Run mode: Single Run, Sweeps and Corners
Tests:
  ee477_library1_FullAdder_1: ee477_library1/FullAdder/schematic, simulator spectre
