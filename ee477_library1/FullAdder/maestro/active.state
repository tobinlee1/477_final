ADE simulation setup
Test ee477_library1_FullAdder_1: ee477_library1/FullAdder/schematic, simulator spectre
  Models: /home/ee577@vlab.usc.edu/CDS_GPDK45/gpdk045_v_5_0/gpdk045/../models/spectre/gpdk045.scs[mc]
  Temperature: 27
  Stimulus A: voltage bit val1=1 val0=0 rise=10ps fall=10ps period=1ns srcType=bit data=000000
  Stimulus B: voltage bit val1=1 val0=0 rise=10ps fall=10ps period=1ns srcType=bit data=111111
  Stimulus Cin: voltage bit val1=1 val0=0 rise=10ps fall=10ps period=1ns srcType=bit data=010101
  Stimulus gnd: voltage dc dc=1 srcType=dc
  Stimulus Vdd: voltage dc dc=1 srcType=dc
  Analysis tran: stop=10n
  Signals: /A, /B, /Vdd, /gnd, /S, /Cout, /Cin
Run mode: Single Run, Sweeps and Corners
