ADE simulation setup
Run mode: Single Run, Sweeps and Corners
Tests:
  ee477_library1_MUX_tb_1: ee477_library1/MUX_tb/schematic, simulator spectre
