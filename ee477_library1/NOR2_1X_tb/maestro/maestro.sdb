ADE simulation setup
Run mode: Single Run, Sweeps and Corners
Tests:
  ee477_library1_NOR2_1X_tb_1: ee477_library1/NOR2_1X_tb/schematic, simulator spectre
