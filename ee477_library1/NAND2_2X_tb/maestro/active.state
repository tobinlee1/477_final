ADE simulation setup
Test ee477_library1_NAND2_2X_tb_1: ee477_library1/NAND2_2X_tb/schematic, simulator spectre
  Models: /home/ee577@vlab.usc.edu/CDS_GPDK45/gpdk045_v_5_0/gpdk045/../models/spectre/gpdk045.scs[mc]
  Temperature: 27
  Stimulus Vdd: voltage dc dc=1 srcType=dc
  Stimulus gnd: voltage dc dc=0 srcType=dc
  Stimulus in_a: voltage bit val1=1 val0=0 rise=10ps fall=10ps period=1n srcType=bit data=0100010
  Stimulus in_b: voltage bit val1=1 val0=0 rise=10ps fall=10ps period=1n srcType=bit data=0001010
  Analysis tran: stop=10n
  Signals: /in_a, /in_b, /Vdd, /gnd, /out_a
Run mode: Single Run, Sweeps and Corners
