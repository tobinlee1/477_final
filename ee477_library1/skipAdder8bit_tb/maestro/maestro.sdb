ADE simulation setup
Run mode: Single Run, Sweeps and Corners
Tests:
  ee477_library1_skipAdder8bit_tb_1: ee477_library1/skipAdder8bit_tb/config, simulator spectre
