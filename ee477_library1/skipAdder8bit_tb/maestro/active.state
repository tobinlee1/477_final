ADE simulation setup
Test ee477_library1_skipAdder8bit_tb_1: ee477_library1/skipAdder8bit_tb/config, simulator spectre
  Models: /home/ee577@vlab.usc.edu/CDS_GPDK45/gpdk045_v_5_0/gpdk045/../models/spectre/gpdk045.scs[mc]
  Temperature: 27
  Stimulus Cin: voltage bit val1=1 val0=0 rise=10ps fall=10ps period=1n srcType=bit data=0010
  Stimulus B3: voltage bit val1=1 val0=0 rise=10ps fall=10ps period=1n srcType=bit data=0000
  Stimulus B7: voltage bit val1=1 val0=0 rise=10ps fall=10ps period=1n srcType=bit data=0000
  Stimulus B2: voltage bit val1=1 val0=0 rise=10ps fall=10ps period=1n srcType=bit data=0000
  Stimulus B6: voltage bit val1=1 val0=0 rise=10ps fall=10ps period=1n srcType=bit data=0000
  Stimulus B1: voltage bit val1=1 val0=0 rise=10ps fall=10ps period=1n srcType=bit data=0001
  Stimulus B5: voltage bit val1=1 val0=0 rise=10ps fall=10ps period=1n srcType=bit data=0001
  Stimulus gnd: voltage dc dc=0 srcType=dc
  Stimulus B0: voltage bit val1=1 val0=0 rise=10ps fall=10ps period=1n srcType=bit data=1101
  Stimulus B4: voltage bit val1=1 val0=0 rise=10ps fall=10ps period=1n srcType=bit data=0001
  Stimulus Vdd: voltage dc dc=1 srcType=dc
  Stimulus A3: voltage bit val1=1 val0=0 rise=10ps fall=10ps period=1n srcType=bit data=1110
  Stimulus A7: voltage bit val1=1 val0=0 rise=10ps fall=10ps period=1n srcType=bit data=0110
  Stimulus A2: voltage bit val1=1 val0=0 rise=10ps fall=10ps period=1n srcType=bit data=1111
  Stimulus A6: voltage bit val1=1 val0=0 rise=10ps fall=10ps period=1n srcType=bit data=0111
  Stimulus A1: voltage bit val1=1 val0=0 rise=10ps fall=10ps period=1n srcType=bit data=1110
  Stimulus A5: voltage bit val1=1 val0=0 rise=10ps fall=10ps period=1n srcType=bit data=0110
  Stimulus A0: voltage bit val1=1 val0=0 rise=10ps fall=10ps period=1n srcType=bit data=1111
  Stimulus A4: voltage bit val1=1 val0=0 rise=10ps fall=10ps period=1n srcType=bit data=0111
  Analysis tran: stop=10n
  Signals: /A0, /A1, /A2, /A3, /B0, /B1, /B2, /B3, /Cin, /A4, /A5, /A6, /A7, /B4, /B5, /B6, /B7, /S0, /S1, /S2, /S3, /S4, /S5, /S6, /S7, /Cout, /Vdd, /gnd
Run mode: Single Run, Sweeps and Corners
