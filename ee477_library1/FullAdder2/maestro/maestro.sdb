ADE simulation setup
Run mode: Single Run, Sweeps and Corners
Tests:
  ee477_library1_FullAdder2_1: ee477_library1/FullAdder2/schematic, simulator spectre
