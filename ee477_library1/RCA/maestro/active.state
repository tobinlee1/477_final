ADE simulation setup
Test ee477_library1_RCA_1: ee477_library1/RCA/schematic, simulator spectre
  Models: /home/ee577@vlab.usc.edu/CDS_GPDK45/gpdk045_v_5_0/gpdk045/../models/spectre/gpdk045.scs[mc]
  Temperature: 27
  Stimulus A0: voltage bit val1=1 val0=0 rise=10ps fall=10ps period=1n srcType=bit data=011
  Stimulus B0: voltage bit val1=1 val0=0 rise=10ps fall=10ps period=1n srcType=bit data=000
  Stimulus C0: voltage bit val1=1 val0=0 rise=10ps fall=10ps period=1n srcType=bit data=010
  Stimulus Vdd: voltage dc dc=1 srcType=dc
  Stimulus gnd: voltage dc dc=0 srcType=dc
  Stimulus A1: voltage bit val1=1 val0=0 rise=10ps fall=10ps period=1n srcType=bit data=001
  Stimulus B1: voltage bit val1=1 val0=0 rise=10ps fall=10ps period=1n srcType=bit data=010
  Stimulus A2: voltage bit val1=1 val0=0 rise=10ps fall=10ps period=1n srcType=bit data=000
  Stimulus B2: voltage bit val1=1 val0=0 rise=10ps fall=10ps period=1n srcType=bit data=011
  Stimulus A3: voltage bit val1=1 val0=0 rise=10ps fall=10ps period=1n srcType=bit data=000
  Stimulus B3: voltage bit val1=1 val0=0 rise=10ps fall=10ps period=1n srcType=bit data=011
  Analysis tran: stop=10n
  Signals: /A0, /B0, /C0, /S0, /A1, /B1, /S1, /A2, /B2, /S2, /A3, /B3, /S3, /Cout, /Vdd, /gnd
Run mode: Single Run, Sweeps and Corners
