ADE simulation setup
Run mode: Single Run, Sweeps and Corners
Tests:
  ee477_library1_RCA_1: ee477_library1/RCA/schematic, simulator spectre
