ADE simulation setup
Test ee477_library1_MUX_1X_1: ee477_library1/MUX_1X/schematic, simulator spectre
  Models: /home/ee577@vlab.usc.edu/CDS_GPDK45/gpdk045_v_5_0/gpdk045/../models/spectre/gpdk045.scs[mc]
  Temperature: 27
  Stimulus Vdd: voltage dc dc=1 srcType=dc
  Stimulus gnd: voltage dc dc=0 srcType=dc
  Stimulus A: voltage bit val1=1 val0=0 rise=10ps fall=10ps period=1n srcType=bit data=00110011
  Stimulus B: voltage bit val1=1 val0=0 rise=10ps fall=10ps period=1n srcType=bit data=01010101
  Stimulus S: voltage bit val1=1 val0=0 rise=10ps fall=10ps period=1n srcType=bit data=00001111
  Stimulus SBar: voltage bit val1=1 val0=0 rise=10ps fall=10ps period=1n srcType=bit data=11110000
  Analysis tran: stop=10n
  Signals: /S, /A, /B, /SBar, /Vdd, /gnd, /OUT
Run mode: Single Run, Sweeps and Corners
