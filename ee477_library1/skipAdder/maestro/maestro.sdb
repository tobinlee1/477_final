ADE simulation setup
Run mode: Single Run, Sweeps and Corners
Tests:
  ee477_library1_skipAdder_1: ee477_library1/skipAdder/schematic, simulator spectre
