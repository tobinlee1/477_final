ADE simulation setup
Test ee477_library1_skipAdder_1: ee477_library1/skipAdder/schematic, simulator spectre
  Models: /home/ee577@vlab.usc.edu/CDS_GPDK45/gpdk045_v_5_0/gpdk045/../models/spectre/gpdk045.scs[mc]
  Temperature: 27
  Stimulus Vdd: voltage dc dc=1 srcType=dc
  Stimulus gnd: voltage dc dc=0 srcType=dc
  Stimulus C0: voltage bit val1=1 val0=0 rise=10ps fall=10ps period=1n srcType=bit data=0100
  Stimulus B3: voltage bit val1=1 val0=0 rise=10ps fall=10ps period=1n srcType=bit data=1000
  Stimulus B2: voltage bit val1=1 val0=0 rise=10ps fall=10ps period=1n srcType=bit data=0000
  Stimulus B1: voltage bit val1=1 val0=0 rise=10ps fall=10ps period=1n srcType=bit data=0001
  Stimulus B0: voltage bit val1=1 val0=0 rise=10ps fall=10ps period=1n srcType=bit data=0001
  Stimulus A3: voltage bit val1=1 val0=0 rise=10ps fall=10ps period=1ns srcType=bit data=1110
  Stimulus A2: voltage bit val1=1 val0=0 rise=10ps fall=10ps period=1ns srcType=bit data=1111
  Stimulus A1: voltage bit val1=1 val0=0 rise=10ps fall=10ps period=1ns srcType=bit data=1110
  Stimulus A0: voltage bit val1=1 val0=0 rise=10ps fall=10ps period=1ns srcType=bit data=1111
  Analysis tran: stop=10n
  Signals: /A0, /A1, /A2, /A3, /B0, /B1, /B2, /B3, /C0, /S0, /S1, /S2, /S3, /P1, /P0, /P2, /P3, /BP, /NBP, /Cout, /Vdd, /gnd
Run mode: Single Run, Sweeps and Corners
