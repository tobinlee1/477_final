ADE simulation setup
Run mode: Single Run, Sweeps and Corners
Tests:
  ee477_library1_INV_tb_1: ee477_library1/INV_tb/config, simulator spectre
    Outputs: /in_a; /Vdd; /gnd; /out_a; /DUT_in
