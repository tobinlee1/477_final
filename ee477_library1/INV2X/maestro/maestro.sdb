ADE simulation setup
Run mode: Single Run, Sweeps and Corners
Tests:
  ee477_library1_INV2X_1: ee477_library1/INV2X/schematic, simulator spectre
