ADE simulation setup
Run mode: Single Run, Sweeps and Corners
Tests:
  ee477_library1_INV_1: ee477_library1/INV/schematic, simulator spectre
    Outputs: /in_a; /out_a
