ADE simulation setup
Run mode: Single Run, Sweeps and Corners
Tests:
  ee477_library1_XOR_1: ee477_library1/XOR/schematic, simulator spectre
