ADE simulation setup
Run mode: Single Run, Sweeps and Corners
Tests:
  ee477_library1_FullAdder_tb_1: ee477_library1/FullAdder_tb/schematic, simulator spectre
