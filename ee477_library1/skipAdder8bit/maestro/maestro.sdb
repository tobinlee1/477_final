ADE simulation setup
Run mode: Single Run, Sweeps and Corners
Tests:
  ee477_library1_skipAdder_tb_1: ee477_library1/skipAdder8bit/schematic, simulator spectre
