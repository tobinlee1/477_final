ADE simulation setup
Run mode: Single Run, Sweeps and Corners
Tests:
  ee477_library1_NAND2X_1: ee477_library1/NAND2_1X/schematic, simulator spectre
    Outputs: /A; /B; /Vdd; /Gnd; /out
