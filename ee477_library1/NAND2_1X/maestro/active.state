ADE simulation setup
Test ee477_library1_NAND2X_1: ee477_library1/NAND2_1X/schematic, simulator spectre
  Models: /home/ee577@vlab.usc.edu/CDS_GPDK45/gpdk045_v_5_0/gpdk045/../models/spectre/gpdk045.scs[mc]
  Temperature: 27
  Stimulus A: voltage bit val1=1 val0=0 rise=10ps fall=10ps period=1n srcType=bit data=1010101010
  Stimulus B: voltage bit val1=1 val0=0 rise=10ps fall=10ps period=1n srcType=bit data=1100110011
  Stimulus Vdd: voltage dc dc=1 srcType=dc
  Stimulus Gnd: voltage dc dc=0 srcType=dc
  Analysis tran: stop=10n
  Signals: /A, /B, /Vdd, /Gnd, /out
Run mode: Single Run, Sweeps and Corners
