ADE simulation setup
Run mode: Single Run, Sweeps and Corners
Tests:
  ee477_library1_XOR_tb_1: ee477_library1/XOR_tb/schematic, simulator spectre
