ADE simulation setup
Run mode: Single Run, Sweeps and Corners
Tests:
  ee477_library1_MUX_4X_1: ee477_library1/MUX_4X/schematic, simulator spectre
