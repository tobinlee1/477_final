ADE simulation setup
Run mode: Single Run, Sweeps and Corners
Tests:
  ee477_library1_INV2X_tb_1: ee477_library1/INV2X_tb/schematic, simulator spectre
