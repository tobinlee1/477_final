ADE simulation setup
Run mode: Single Run, Sweeps and Corners
Tests:
  DFF_ddf_r_1: DFF/ddf_r/schematic, simulator spectre
