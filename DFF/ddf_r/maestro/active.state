ADE simulation setup
Test DFF_ddf_r_1: DFF/ddf_r/schematic, simulator spectre
  Models: /home/ee577@vlab.usc.edu/CDS_GPDK45/gpdk045_v_5_0/gpdk045/../models/spectre/gpdk045.scs[mc]
  Temperature: 27
  Stimulus rst: voltage bit val1=1 val0=0 rise=100p fall=100p period=10n srcType=bit data=1100000000
  Stimulus Vdd: voltage dc dc=1 srcType=dc
  Stimulus gnd: voltage dc dc=0 srcType=dc
  Stimulus clk: voltage bit val1=1 val0=0 rise=100p fall=100p period=1n srcType=bit data=0011111000001111100000111110000011111000001111100000111110000011111000001111100000111110000011111000
  Stimulus d: voltage bit val1=1 val0=0 rise=100p fall=100p period=10n srcType=bit data=0110110111
  Analysis tran: stop=110n
  Signals: /rst, /clk, /d, /qb, /q, /Vdd, /gnd
Run mode: Single Run, Sweeps and Corners
