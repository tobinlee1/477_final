ADE simulation setup
Test DFF_ddf_r_1: DFF/ddf_r/schematic, simulator spectre
  Models: /home/ee577@vlab.usc.edu/CDS_GPDK45/gpdk045_v_5_0/gpdk045/../models/spectre/gpdk045.scs[mc]
  Temperature: 27
  Files: vectors /home/tobinlee@vlab.usc.edu/work_gpdk045/VEC_files/t10_dff_r.vec
  Stimulus Vdd: voltage dc dc=1 srcType=dc
  Stimulus gnd: voltage dc dc=0 srcType=dc
  Analysis tran: stop=110n
  Signals: /rst, /clk, /d, /qb, /q, /Vdd, /gnd
Run mode: Single Run, Sweeps and Corners
