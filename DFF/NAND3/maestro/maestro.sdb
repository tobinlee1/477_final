ADE simulation setup
Run mode: Single Run, Sweeps and Corners
Tests:
  DFF_NAND3_1: DFF/NAND3/schematic, simulator spectre
