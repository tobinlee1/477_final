ADE simulation setup
Test DFF_NAND3_1: DFF/NAND3/schematic, simulator spectre
  Models: /home/ee577@vlab.usc.edu/CDS_GPDK45/gpdk045_v_5_0/gpdk045/../models/spectre/gpdk045.scs[mc]
  Temperature: 27
  Stimulus A: voltage bit val1=1 val0=0 rise=10ps fall=10ps period=1n srcType=bit data=00001111
  Stimulus gnd: voltage dc dc=0 srcType=dc
  Stimulus Vdd: voltage dc dc=1 srcType=dc
  Stimulus B: voltage bit val1=1 val0=0 rise=10ps fall=10ps period=1n srcType=bit data=00110011
  Stimulus C: voltage bit val1=1 val0=0 rise=10ps fall=10ps period=1n srcType=bit data=01010101
  Analysis tran: stop=10n
  Signals: /A, /B, /C, /Vdd, /gnd, /Out
Run mode: Single Run, Sweeps and Corners
