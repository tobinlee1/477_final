ADE simulation setup
Test Result_Stage_NOR4_1: Result_Stage/NOR4/schematic, simulator spectre
  Models: /home/ee577@vlab.usc.edu/CDS_GPDK45/gpdk045_v_5_0/gpdk045/../models/spectre/gpdk045.scs[mc]
  Temperature: 27
  Stimulus a: voltage bit val1=1 val0=0 rise=10p fall=10p period=1n srcType=bit data=11110
  Stimulus b: voltage bit val1=1 val0=0 rise=10p fall=10p period=1n srcType=bit data=11100
  Stimulus c: voltage bit val1=1 val0=0 rise=10p fall=10p period=1n srcType=bit data=11000
  Stimulus d: voltage bit val1=1 val0=0 rise=10p fall=10p period=1n srcType=bit data=10000
  Stimulus Vdd: voltage dc dc=1 srcType=dc
  Stimulus gnd: voltage dc dc=0 srcType=dc
  Analysis tran: stop=10n
  Signals: /a, /b, /c, /d, /out
Run mode: Single Run, Sweeps and Corners
