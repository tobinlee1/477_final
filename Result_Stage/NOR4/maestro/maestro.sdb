ADE simulation setup
Run mode: Single Run, Sweeps and Corners
Tests:
  Result_Stage_NOR4_1: Result_Stage/NOR4/schematic, simulator spectre
