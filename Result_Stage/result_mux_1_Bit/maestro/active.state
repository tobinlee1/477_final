ADE simulation setup
Test Result_Stage_result_mux_1_Bit_1: Result_Stage/result_mux_1_Bit/schematic, simulator spectre
  Models: /home/ee577@vlab.usc.edu/CDS_GPDK45/gpdk045_v_5_0/gpdk045/../models/spectre/gpdk045.scs[mc]
  Temperature: 27
  Stimulus add_i: voltage bit val1=1 val0=0 rise=10p fall=10p period=1n srcType=bit data=00000
  Stimulus logic_i: voltage bit val1=1 val0=0 rise=10p fall=10p period=1n srcType=bit data=00000
  Stimulus shift_i: voltage bit val1=1 val0=0 rise=10p fall=10p period=1n srcType=bit data=00000
  Stimulus grp1: voltage bit val1=1 val0=0 rise=10p fall=10p period=1n srcType=bit data=00000
  Stimulus ld_res: voltage bit val1=1 val0=0 rise=10p fall=10p period=1n srcType=bit data=00000
  Stimulus grp0: voltage bit val1=1 val0=0 rise=10p fall=10p period=1n srcType=bit data=00000
  Stimulus clk: voltage bit val1=1 val0=0 rise=10p fall=10p period=1n srcType=bit data=00000
  Stimulus rst: voltage bit val1=1 val0=0 rise=10p fall=10p period=1n srcType=bit data=010101
  Stimulus Vdd: voltage dc dc=1 srcType=dc
  Stimulus gnd: voltage dc dc=0 srcType=dc
  Analysis tran: stop=10n
  Signals: /grp0, /grp1, /ld_res, /logic_i, /result_i, /rst, /shift_i
Run mode: Single Run, Sweeps and Corners
