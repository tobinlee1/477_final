ADE simulation setup
Run mode: Single Run, Sweeps and Corners
Tests:
  Result_Stage_result_mux_1_Bit_1: Result_Stage/result_mux_1_Bit/schematic, simulator spectre
