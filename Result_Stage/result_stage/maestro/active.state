ADE simulation setup
Test Result_Stage_result_stage_1: Result_Stage/result_stage/schematic, simulator spectre
  Models: /home/ee577@vlab.usc.edu/CDS_GPDK45/gpdk045_v_5_0/gpdk045/../models/spectre/gpdk045.scs[mc]
  Temperature: 27
  Files: vectors /home/tobinlee@vlab.usc.edu/work_gpdk045/VEC_files/t4_result_stage.vec
  Stimulus Vdd: voltage dc dc=1 srcType=dc
  Stimulus gnd: voltage dc dc=0 srcType=dc
  Analysis tran: stop=110n
  Signals: /add_i_1, /add_i_2, /add_i_3, /add_i_4, /add_i_5, /add_i_6, /add_i_7, /logic_i_0, /shift_i_7, /shift_i_6, /shift_i_5, /shift_i_4, /shift_i_3, /shift_i_2, /shift_i_1, /shift_i_0, /logic_i_7, /logic_i_6, /logic_i_5, /logic_i_4, /logic_i_3, /logic_i_2, /logic_i_1, /add_i_0, /result_1, /result_2, /result_3, /result_4, /result_5, /result_6, /result_7, /result_0, /C, /N, /Z, /V, /arith, /ld_res, /rst, /c8, /c7, /grp0, /grp1
Run mode: Single Run, Sweeps and Corners
