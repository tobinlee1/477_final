ADE simulation setup
Run mode: Single Run, Sweeps and Corners
Tests:
  Result_Stage_result_stage_1: Result_Stage/result_stage/schematic, simulator spectre
