ADE simulation setup
Test shift8_ibsa_shift8_tb_1: shift8_ibsa/shift8_tb/schematic, simulator spectre
  Models: /home/ee577@vlab.usc.edu/CDS_GPDK45/gpdk045_v_5_0/gpdk045/../models/spectre/gpdk045.scs[mc]
  Temperature: 27
  Files: vectors /home/abadiga@vlab.usc.edu/work_gpdk045/ALU_vectors/t3_shift8/t3_shift8.vec
  Analysis tran: stop=130n
  Signals: /A7, /A6, /A5, /A4, /A3, /A2, /A1, /A0, /sh2, /sh1, /sh0, /y7, /y6, /y5, /y4, /y3, /y2, /y1, /y0
Run mode: Single Run, Sweeps and Corners
