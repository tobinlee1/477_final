ADE simulation setup
Run mode: Single Run, Sweeps and Corners
Tests:
  shift8_ibsa_shift8_tb_1: shift8_ibsa/shift8_tb/schematic, simulator spectre
