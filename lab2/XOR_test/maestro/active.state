ADE simulation setup
Test lab2_XOR_1: lab2/XOR_test/schematic, simulator spectre
  Models: /home/ee577@vlab.usc.edu/CDS_GPDK45/gpdk045_v_5_0/gpdk045/../models/spectre/gpdk045.scs[mc]
  Temperature: 27
  Stimulus in_A: voltage bit val1=1 val0=0 rise=10p fall=10p period=1n srcType=bit data=10001
  Stimulus in_B: voltage bit val1=1 val0=0 rise=10p fall=10p period=1n srcType=bit data=11000
  Stimulus gnd: voltage dc dc=0 srcType=dc
  Stimulus vdd: voltage dc dc=1 srcType=dc
  Analysis tran: stop=10n
  Signals: /vdd, /in_A, /in_B, /out_A, /gnd
Run mode: Single Run, Sweeps and Corners
