ADE simulation setup
Run mode: Single Run, Sweeps and Corners
Tests:
  lab2_XOR_1: lab2/XOR_test/schematic, simulator spectre
