ADE simulation setup
Run mode: Single Run, Sweeps and Corners
Tests:
  lab2_XOR_1: lab2/XOR/schematic, simulator spectre
