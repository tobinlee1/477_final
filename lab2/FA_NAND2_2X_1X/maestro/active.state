ADE simulation setup
Test lab2_FA_NAND2_2X_1X_1: lab2/FA_NAND2_1X_2X/schematic, simulator spectre
  Models: /home/ee577@vlab.usc.edu/CDS_GPDK45/gpdk045_v_5_0/gpdk045/../models/spectre/gpdk045.scs[mc]
  Temperature: 27
  Stimulus In_A: voltage bit val1=1 val0=0 rise=10p fall=10p period=1n srcType=bit data=000
  Stimulus in_B: voltage bit val1=1 val0=0 rise=10p fall=10p period=1n srcType=bit data=111
  Stimulus Cin: voltage bit val1=1 val0=0 rise=10p fall=10p period=1n srcType=bit data=010
  Stimulus Vdd: voltage dc dc=1 srcType=dc
  Stimulus gnd: voltage dc dc=0 srcType=dc
  Analysis tran: stop=10n
  Signals: /dut_in_A, /dut_in_B, /dut_in_C, /dut_out_c, /dut_out_s, /Cin, /Cout, /In_A, /in_B, /S
Run mode: Single Run, Sweeps and Corners
