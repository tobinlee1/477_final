ADE simulation setup
Test lab2_XOR_DUT_1: lab2/XOR_DUT/schematic, simulator spectre
  Models: /home/ee577@vlab.usc.edu/CDS_GPDK45/gpdk045_v_5_0/gpdk045/../models/spectre/gpdk045.scs[mc]
  Temperature: 27
  Stimulus Vdd: voltage dc dc=1 srcType=dc
  Stimulus gnd: voltage dc dc=0 srcType=dc
  Stimulus in_A: voltage bit val1=1 val0=0 rise=10p fall=10p period=1n srcType=bit data=0011100001100011
  Stimulus in_B: voltage bit val1=1 val0=0 rise=10p fall=10p period=1n srcType=bit data=0110001100111000
  Analysis tran: stop=16n
  Output VT("/dut_in_A") (unticked)
  Output tPLH_A_01_B00 = delay(?wf1 VT("/dut_in_A") ?value1 0.5 ?edge1 "rising" ?nth1 1 ?td1 1.09e-08 ?tol1 nil ?wf2 VT("/dut_out") ?value2 0.5 ?edge2 "rising" ?nth2 1 ?tol2 nil ?td2r0 1.09e-08 ?stop 1.15e-08 ?multiple nil) (unticked)
  Signals: /in_A, /in_B, /dut_in_B, /dut_in_A, /dut_out, /out_A
Run mode: Single Run, Sweeps and Corners
