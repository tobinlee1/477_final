ADE simulation setup
Run mode: Single Run, Sweeps and Corners
Tests:
  lab2_XOR_DUT_1: lab2/XOR_DUT/schematic, simulator spectre
