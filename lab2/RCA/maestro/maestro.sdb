ADE simulation setup
Run mode: Single Run, Sweeps and Corners
Tests:
  lab2_RCA_1: lab2/RCA/schematic, simulator spectre
