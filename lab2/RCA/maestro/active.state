ADE simulation setup
Test lab2_RCA_1: lab2/RCA/schematic, simulator spectre
  Models: /home/ee577@vlab.usc.edu/CDS_GPDK45/gpdk045_v_5_0/gpdk045/../models/spectre/gpdk045.scs[mc]
  Temperature: 27
  Stimulus Vdd: voltage dc dc=1 srcType=dc
  Stimulus gnd: voltage dc dc=0 srcType=dc
  Stimulus in_B0: voltage bit val1=1 val0=0 rise=10p fall=10p period=1n srcType=bit data=0000
  Stimulus in_A1: voltage bit val1=1 val0=0 rise=10p fall=10p period=1n srcType=bit data=1111
  Stimulus Cin: voltage bit val1=1 val0=0 rise=10p fall=10p period=1n srcType=bit data=0111
  Stimulus in_A0: voltage bit val1=1 val0=0 rise=10p fall=10p period=1n srcType=bit data=1111
  Stimulus in_A2: voltage bit val1=1 val0=0 rise=10p fall=10p period=1n srcType=bit data=1111
  Stimulus in_B1: voltage bit val1=1 val0=0 rise=10p fall=10p period=1n srcType=bit data=0000
  Stimulus in_B2: voltage bit val1=1 val0=0 rise=10p fall=10p period=1n srcType=bit data=0000
  Stimulus in_B3: voltage bit val1=1 val0=0 rise=10p fall=10p period=1n srcType=bit data=0000
  Stimulus in_A3: voltage bit val1=1 val0=0 rise=10p fall=10p period=1n srcType=bit data=1111
  Analysis tran: stop=10n
  Signals: /S0, /S1, /S2, /S3, /Cout, /in_A0, /in_A1, /in_A2, /in_A3, /in_B0, /in_B1, /in_B2, /Cin
Run mode: Single Run, Sweeps and Corners
