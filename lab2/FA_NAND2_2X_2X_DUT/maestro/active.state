ADE simulation setup
Test lab2_FA_NAND2_2X_1X_DUT_1: lab2/FA_NAND2_2X_1X_DUT/schematic, simulator spectre
  Models: /home/ee577@vlab.usc.edu/CDS_GPDK45/gpdk045_v_5_0/gpdk045/../models/spectre/gpdk045.scs[mc]
  Temperature: 27
  Stimulus Cin: voltage bit val1=1 val0=0 rise=1p fall=1p period=1n srcType=bit data=010
  Stimulus in_A: voltage bit val1=1 val0=0 rise=1p fall=1p period=1n srcType=bit data=000
  Stimulus in_B: voltage bit val1=1 val0=0 rise=1p fall=1p period=1n srcType=bit data=111
  Stimulus Vdd: voltage dc dc=1 srcType=dc
  Stimulus gnd: voltage dc dc=0 srcType=dc
  Analysis tran: stop=10n
  Signals: /in_A, /in_B, /Cin, /Cout, /S, /dut_in_A, /dut_in_B, /dut_in_C, /dut_out_c, /dut_out_s
Test lab2_FA_NAND2_2X_2X_DUT_1: lab2/FA_NAND2_2X_2X_DUT/schematic, simulator spectre
  Models: /home/ee577@vlab.usc.edu/CDS_GPDK45/gpdk045_v_5_0/gpdk045/../models/spectre/gpdk045.scs[mc]
  Temperature: 27
  Stimulus Cin: voltage bit val1=1 val0=0 rise=1p fall=1p period=1n srcType=bit data=010
  Stimulus in_A: voltage bit val1=1 val0=0 rise=1p fall=1p period=1n srcType=bit data=000
  Stimulus in_B: voltage bit val1=1 val0=0 rise=1p fall=1p period=1n srcType=bit data=111
  Stimulus Vdd: voltage dc dc=1 srcType=dc
  Stimulus gnd: voltage dc dc=0 srcType=dc
  Analysis tran: stop=10n
  Signals: /in_A, /in_B, /Cin, /Cout, /S, /dut_in_A, /dut_in_B, /dut_in_C, /dut_out_c, /dut_out_s
