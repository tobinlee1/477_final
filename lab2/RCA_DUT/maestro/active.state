ADE simulation setup
Test lab2_RCA_DUT_1: lab2/RCA_DUT/schematic, simulator spectre
  Models: /home/ee577@vlab.usc.edu/CDS_GPDK45/gpdk045_v_5_0/gpdk045/../models/spectre/gpdk045.scs[mc]
  Temperature: 27
  Stimulus A0: voltage bit val1=1 val0=0 rise=10ps fall=10ps period=1n srcType=bit data=1111
  Stimulus B0: voltage bit val1=1 val0=0 rise=10ps fall=10ps period=1n srcType=bit data=0000
  Stimulus A1: voltage bit val1=1 val0=0 rise=10ps fall=10ps period=1n srcType=bit data=1111
  Stimulus A2: voltage bit val1=1 val0=0 rise=10ps fall=10ps period=1n srcType=bit data=1111
  Stimulus A3: voltage bit val1=1 val0=0 rise=10ps fall=10ps period=1n srcType=bit data=1111
  Stimulus B1: voltage bit val1=1 val0=0 rise=10ps fall=10ps period=1n srcType=bit data=0000
  Stimulus B2: voltage bit val1=1 val0=0 rise=10ps fall=10ps period=1n srcType=bit data=0000
  Stimulus B3: voltage bit val1=1 val0=0 rise=10ps fall=10ps period=1n srcType=bit data=0000
  Stimulus C0: voltage bit val1=1 val0=0 rise=10ps fall=10ps period=1n srcType=bit data=0110
  Stimulus vDD: voltage dc dc=1 srcType=dc
  Stimulus gnd: voltage dc dc=0 srcType=dc
  Analysis tran: stop=10n
  Signals: /S2, /S1, /S0, /S3, /C4, /A0, /B0, /A1, /B1, /A2, /B2, /A3, /C0, /B3, /DB0, /DC4, /DC0, /DS3
Run mode: Single Run, Sweeps and Corners
