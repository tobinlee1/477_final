ADE simulation setup
Run mode: Single Run, Sweeps and Corners
Tests:
  lab2_RCA_DUT_1: lab2/RCA_DUT/schematic, simulator spectre
