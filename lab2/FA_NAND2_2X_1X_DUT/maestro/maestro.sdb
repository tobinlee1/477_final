ADE simulation setup
Run mode: Single Run, Sweeps and Corners
Tests:
  lab2_FA_NAND2_2X_1X_DUT_1: lab2/FA_NAND2_2X_1X_DUT/schematic, simulator spectre
