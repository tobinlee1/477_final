ADE simulation setup
Run mode: Single Run, Sweeps and Corners
Tests:
  lab2_FA_V2_DUT_1: lab2/FA_V2_DUT/schematic, simulator spectre
